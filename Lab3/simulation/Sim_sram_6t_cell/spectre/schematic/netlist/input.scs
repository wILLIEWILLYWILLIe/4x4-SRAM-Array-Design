// Design: my_sram/Sim_sram_6t_cell
simulator lang=spectre
global 0
parameters vdd=1.1
include "/vol/eecs391/FreePDK45/ncsu_basekit/models/hspice/hspice_nom.include"

// EECS391/inverter/schematic
subckt inverter gnd in out vdd
    M0 (out in gnd gnd) NMOS_VTG w=400n l=50n ld=105n ls=105n m=1
    M1 (out in vdd vdd) PMOS_VTG w=600n l=50n ld=105n ls=105n m=1
ends inverter

// my_sram/sram_6t_cell/schematic
subckt sram_6t_cell BL BLB GND VDD WL
    M5 (net18 net14 GND GND) NMOS_VTG w=240.0n l=50n ld=105n ls=105n m=1
    M4 (net14 net14 GND GND) NMOS_VTG w=240.0n l=50n ld=105n ls=105n m=1
    M3 (BLB WL net18 GND) NMOS_VTG w=135.00n l=50n ld=105n ls=105n m=1
    M2 (net14 WL BL GND) NMOS_VTG w=135.00n l=50n ld=105n ls=105n m=1
    M7 (net18 net14 VDD VDD) PMOS_VTG w=90n l=50n ld=105n ls=105n m=1
    M6 (net14 net14 VDD VDD) PMOS_VTG w=90n l=50n ld=105n ls=105n m=1
ends sram_6t_cell

// my_sram/Sim_sram_6t_cell/schematic
I21 (gnd net010 in_BLB vdd) inverter
I20 (gnd in_BL net021 vdd) inverter
I19 (gnd in_BL net022 vdd) inverter
I18 (gnd in_BL net023 vdd) inverter
I15 (gnd net011 in_BL vdd) inverter
I13 (gnd in_BLB net09 vdd) inverter
I7 (gnd net2 in_WL vdd) inverter
I17 (gnd in_BL net024 vdd) inverter
I9 (gnd in_BLB net08 vdd) inverter
I10 (gnd in_BLB net07 vdd) inverter
I11 (gnd in_BLB net06 vdd) inverter
V6 (net010 gnd) vsource dc=0 type=pulse val0=1.1 val1=0 period=20n delay=0 rise=20p fall=20p width=10n
V4 (net011 gnd) vsource dc=0 type=pulse val0=0 val1=1.1V period=20n delay=0 rise=20p fall=20p width=10n
V_A (net2 gnd) vsource dc=0 type=pulse val0=0 val1=1.1V period=10n delay=1n rise=20p fall=20p width=5n
V2 (gnd 0) vsource dc=0 type=dc
V1 (vdd 0) vsource dc=vdd type=dc
I16 (in_BL in_BLB gnd vdd in_WL) sram_6t_cell
simulatorOptions options temp=27
tran tran stop=60n errpreset=moderate
save in_WL in_BL in_BLB
